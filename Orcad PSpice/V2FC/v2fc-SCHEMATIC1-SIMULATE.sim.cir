** Profile: "SCHEMATIC1-SIMULATE"  [ c:\users\mohammad al-ahmad\desktop\workshop\orcad\me\v2fc-schematic1-simulate.sim ]

** Creating circuit file "v2fc-schematic1-simulate.sim.cir"
** WARNING: THIS AUTOMATICALLY GENERATED FILE MAY BE OVERWRITTEN BY SUBSEQUENT SIMULATIONS

*Libraries:
* Local Libraries :
* From [PSPICE NETLIST] section of C:\Program Files\Orcad\PSpice\PSpice.ini file:
.lib "nom.lib"

*Analysis directives:
.TRAN  0 50ms 0 1us SKIPBP
.PROBE V(*) I(*) W(*) D(*) NOISE(*)
.INC ".\v2fc-SCHEMATIC1.net"

.END
