** Profile: "SCHEMATIC1-Test"  [ c:\users\mohammad al-ahmad\desktop\workshop\orcad\louay\5551-schematic1-test.sim ]

** Creating circuit file "5551-schematic1-test.sim.cir"
** WARNING: THIS AUTOMATICALLY GENERATED FILE MAY BE OVERWRITTEN BY SUBSEQUENT SIMULATIONS

*Libraries:
* Local Libraries :
* From [PSPICE NETLIST] section of C:\Program Files\Orcad\PSpice\PSpice.ini file:
.lib "nom.lib"

*Analysis directives:
.TRAN  0 500m 0 SKIPBP
.PROBE V(*) I(*) W(*) D(*) NOISE(*)
.INC ".\5551-SCHEMATIC1.net"

.END
